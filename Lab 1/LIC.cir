Piecewise_Linear_voltage_source_U24EC025

c1 out 0 100f
*capacitor is connected between out and 0(gound)
r1 in out 2k
*resistor is connected between in and out

vin in 0 pwl(0ps 0 100ps 0 150ps 1.8V 800ps 1.8V)
.tran 0.5ns 5ns
*.tran 20ps 800ps
.control
set hcopydevtype=svg
set color0 = white
set color1 = black
set xbrushwidth = 3
run
plot v(in)
plot v(out)
plot v(in, out)
plot v(out) v(in) v(in, out)
hardcopy out\pwl_vsource.svg v(in) v(out) v(in, out)
.endc
.end
