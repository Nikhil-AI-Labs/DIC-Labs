* ECL 2-Input NOR and OR Gate with Emitter Follower Outputs
* Truth table (ECL: HIGH=-0.8V, LOW=-1.8V):
*   A=L B=L -> NOR=H OR=L
*   A=L B=H -> NOR=L OR=H
*   A=H B=L -> NOR=L OR=H
*   A=H B=H -> NOR=L OR=H

.title ECL_NOR_OR_Gate

.model Qa NPN (BF=100)

* Input transistors: collectors tied together (wired-OR -> NOR node)
Q1 nor_c a e Qa
Q2 nor_c b e Qa

* Reference transistor: collector = OR node
Q3 or_c vb e Qa

* Emitter follower outputs
Q4 0 nor_c nor_out Qa
Q5 0 or_c  or_out  Qa

* Collector load resistors
RC1 nor_c 0 300
RC2 or_c  0 300

* Emitter resistors
Re  e       vee 1500
Rf1 nor_out vee 1500
Rf2 or_out  vee 1500

* Power supply
VEE vee 0 -5.2

* Reference voltage (node vb, source Vref - different names to avoid clash)
Vref vb 0 -1.3

* Inputs: two pulses at different periods to sweep all 4 input combinations
* t= 0- 8ns: A=L B=L  -> NOR=H OR=L
* t= 8-16ns: A=L B=H  -> NOR=L OR=H
* t=16-24ns: A=H B=L  -> NOR=L OR=H
* t=24-32ns: A=H B=H  -> NOR=L OR=H
VA a 0 PULSE(-1.8 -0.8 0n 0.1n 0.1n 16n 32n)
VB b 0 PULSE(-1.8 -0.8 0n 0.1n 0.1n  8n 16n)

.tran 0.1n 32n

.control
set color0 = white
set color1 = black
set xbrushwidth = 3
set hcopydevtype = svg
run
let A_shifted = a + 2
let B_shifted = b + 4
let or_shifetd = or_out + 6
plot v(A_shifted) v(B_shifted) v(nor_out) v(or_shifetd)
.endc

.end
