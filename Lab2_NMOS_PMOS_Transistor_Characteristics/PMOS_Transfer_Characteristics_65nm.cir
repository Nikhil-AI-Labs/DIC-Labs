// Aim  : Plot transfer characteristic and output characteristic of NMOS and PMOS using ngspice

.title PMOS_Transfer_Characteristic_65nm_U24ec025
.include cmos_65nm.txt

m1 d g 0 0 pmos w=32u l= 65nm
vgs g 0 -1.2
vds d 0 -1.2

.dc vgs -0.5 -1.2 -0.02 vds 0 -1.2 -0.6

*.dc vds 0 -1.2 -0.02 vgs 0 -1.2 -0.3

.control

set color0 = white
set color1 = black

set xbrushwidth = 3
set hcopydevtype = svg
run
plot -I(vgs)
plot -I(vds)
hardcopy output\PMOS_Transfer_Characteristics_65nm.svg -I(vgs)
.endc
.end
